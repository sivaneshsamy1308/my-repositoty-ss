# Ansys Electronics Desktop project, version 2023.2
materials:
  vacuum: permittivity=1
  FR4_epoxy: permittivity=4.4 dielectric_loss_tangent=0.02

design HFSSDesign1 (HFSS, HFSS Modal Network, model units in)
options: Save_Adaptive_support_files
variables:
  offset = 0.2n
geometry:
  Box1 [vacuum] = box(corner=(0in, 0.45in, 0in), size=(2in, 0.5in, 0.4in))
  Box1.move(0in, -0.6in, 0in)
  Box1.move(0in, -0.1in, 0in)
  Box1_1 = Box1.duplicate_around_axis(axis=Z, angle=90deg, total=2)
  Box1_2 = Box1.duplicate_around_axis(axis=Z, angle=-90deg, total=2)
  Box1.unite(Box1_2, Box1_1)
  Box2 = box(corner=(-0.45in, offset-0.05in, 0in), size=(0.45in, 0.1in, 0.4in))
  Box2.move(0.2in, 0in, 0in)
  Box1.subtract(Box2)
boundaries and excitations:
  1: Wave Port Faces=Box1.face(+x) WavePortType=Modal NumModes=1 Modes{Mode1{IntLine{(2, 0, 0) -> (2, 0, 0.4)} CharImp=Zpi}}
  2: Wave Port Faces=Box1.face(at (0, 2, 0.2)) WavePortType=Modal NumModes=1 Modes{Mode1{IntLine{(0, 2, 0) -> (0, 2, 0.4)} CharImp=Zpi}}
  3: Wave Port Faces=Box1.face(at (0, -2, 0.2)) WavePortType=Modal NumModes=1 Modes{Mode1{IntLine{(0, -2, 0) -> (0, -2, 0.4)} CharImp=Zpi}}
setups:
  Setup1: HfssDriven Frequency=10GHz MaxDeltaS=0.02 MaximumPasses=6 MinimumPasses=1 MinimumConvergedPasses=1 PercentRefinement=30 BasisOrder=1 PortAccuracy=2 DrivenSolverType="Direct Solver"
    sweep Sweep: 1GHz to 50GHz, 451 points; Type=Interpolating InterpTolerance=0.5 InterpMaxSolns=250 InterpUsePortImped=false PassivityErrorTolerance=0.0001
source amplitudes:
  1:1: 1W 0deg
  2:1, 3:1: 0W 0deg
field plots:
  Mag_E1, Vector_E1: E Field in Box1 on Setup1 : LastAdaptive at Freq=10GHz Phase=0deg
reports:
  S Parameter Plot 3: dB(S(1,1)), dB(S(2,1)), dB(S(3,1)), dB(S(1,2)), dB(S(2,2)), dB(S(3,2)), dB(S(1,3)), dB(S(2,3)), dB(S(3,3)) vs Freq on Setup1 : Sweep
